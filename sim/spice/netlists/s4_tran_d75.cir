* S4 transient: LEDC PWM 20 kHz, duty 0.75
VT pvdd_trim 0 PULSE(0 3.3 0 20n 20n 3.748e-05 5e-05)
* ideal boost: gm-C integrator drives PVDD so that V(FB) = VREF; PVDD >= VSYS - 0.5 V
GINT vint 0 fb vref 0.0235619
CINT vint 0 1e-06
RINT vint 0 1e12
VREF vref 0 1.198
BPV pvdd 0 V = max(v(vint), 6.9)
RUP pvdd fb 300000.0
RDN fb 0 21428.57
R907 trim_k fb 68000.0
D901 trim_rc trim_k D1N4148W
R909 trim_a trim_rc 10000.0
C918 trim_rc 0 1e-06
R908 pvdd_trim trim_a 10000.0
C917 trim_a 0 1e-06
.model D1N4148W D(IS=2.52n RS=0.568 N=1.752 CJO=4p M=0.4 TT=20n BV=75 IBV=5u XTI=3 EG=1.11)

.ic v(vint)=17.97 v(trim_a)=0 v(trim_rc)=0
.options reltol=1e-5 abstol=1e-13 vntol=1e-9
.tran 0.5u 0.3 0 0.5u uic
.end
