* S6 pdm_data
VSRC src 0 PULSE(0 3.3 2n 2.5e-09 2.5e-09 1.603e-07 3.255e-07)
ROUT src pad 50
CPAD pad 0 3p
RS pad a 33
TMB a 0 b 0 Z0=50 TD=2.4e-10
LC1 b c 2.0n
CC1 c 0 0.3p
RFFC c c2 0.4
TFFC c2 0 d 0 Z0=119.8 TD=9.263e-10
LC2 d e 2.0n
CC2 e 0 0.3p
TUI e 0 f 0 Z0=55 TD=1.5e-10
TDM f 0 rx 0 Z0=70 TD=1.5e-10
CRX rx 0 5e-12
.options method=gear
.tran 20p 700n 0 20p
.end
