* S6 crosstalk ladder: conductors 5 (SCLK), 7 (MOSI), 8 (CS), 9 (DC)
Lsclk0 sclk0 sclk0m 2.2185e-09
Rsclk0 sclk0m sclk1 0.01
CGsclk0 sclk1 0 1.7928e-13
Lsclk1 sclk1 sclk1m 2.2185e-09
Rsclk1 sclk1m sclk2 0.01
CGsclk1 sclk2 0 1.7928e-13
Lsclk2 sclk2 sclk2m 2.2185e-09
Rsclk2 sclk2m sclk3 0.01
CGsclk2 sclk3 0 1.7928e-13
Lsclk3 sclk3 sclk3m 2.2185e-09
Rsclk3 sclk3m sclk4 0.01
CGsclk3 sclk4 0 1.7928e-13
Lsclk4 sclk4 sclk4m 2.2185e-09
Rsclk4 sclk4m sclk5 0.01
CGsclk4 sclk5 0 1.7928e-13
Lsclk5 sclk5 sclk5m 2.2185e-09
Rsclk5 sclk5m sclk6 0.01
CGsclk5 sclk6 0 1.7928e-13
Lsclk6 sclk6 sclk6m 2.2185e-09
Rsclk6 sclk6m sclk7 0.01
CGsclk6 sclk7 0 1.7928e-13
Lsclk7 sclk7 sclk7m 2.2185e-09
Rsclk7 sclk7m sclk8 0.01
CGsclk7 sclk8 0 1.7928e-13
Lsclk8 sclk8 sclk8m 2.2185e-09
Rsclk8 sclk8m sclk9 0.01
CGsclk8 sclk9 0 1.7928e-13
Lsclk9 sclk9 sclk9m 2.2185e-09
Rsclk9 sclk9m sclk10 0.01
CGsclk9 sclk10 0 1.7928e-13
Lsclk10 sclk10 sclk10m 2.2185e-09
Rsclk10 sclk10m sclk11 0.01
CGsclk10 sclk11 0 1.7928e-13
Lsclk11 sclk11 sclk11m 2.2185e-09
Rsclk11 sclk11m sclk12 0.01
CGsclk11 sclk12 0 1.7928e-13
Lsclk12 sclk12 sclk12m 2.2185e-09
Rsclk12 sclk12m sclk13 0.01
CGsclk12 sclk13 0 1.7928e-13
Lsclk13 sclk13 sclk13m 2.2185e-09
Rsclk13 sclk13m sclk14 0.01
CGsclk13 sclk14 0 1.7928e-13
Lsclk14 sclk14 sclk14m 2.2185e-09
Rsclk14 sclk14m sclk15 0.01
CGsclk14 sclk15 0 1.7928e-13
Lsclk15 sclk15 sclk15m 2.2185e-09
Rsclk15 sclk15m sclk16 0.01
CGsclk15 sclk16 0 1.7928e-13
Lsclk16 sclk16 sclk16m 2.2185e-09
Rsclk16 sclk16m sclk17 0.01
CGsclk16 sclk17 0 1.7928e-13
Lsclk17 sclk17 sclk17m 2.2185e-09
Rsclk17 sclk17m sclk18 0.01
CGsclk17 sclk18 0 1.7928e-13
Lsclk18 sclk18 sclk18m 2.2185e-09
Rsclk18 sclk18m sclk19 0.01
CGsclk18 sclk19 0 1.7928e-13
Lsclk19 sclk19 sclk19m 2.2185e-09
Rsclk19 sclk19m sclk20 0.01
CGsclk19 sclk20 0 1.7928e-13
Lsclk20 sclk20 sclk20m 2.2185e-09
Rsclk20 sclk20m sclk21 0.01
CGsclk20 sclk21 0 1.7928e-13
Lsclk21 sclk21 sclk21m 2.2185e-09
Rsclk21 sclk21m sclk22 0.01
CGsclk21 sclk22 0 1.7928e-13
Lsclk22 sclk22 sclk22m 2.2185e-09
Rsclk22 sclk22m sclk23 0.01
CGsclk22 sclk23 0 1.7928e-13
Lsclk23 sclk23 sclk23m 2.2185e-09
Rsclk23 sclk23m sclk24 0.01
CGsclk23 sclk24 0 1.7928e-13
Lsclk24 sclk24 sclk24m 2.2185e-09
Rsclk24 sclk24m sclk25 0.01
CGsclk24 sclk25 0 1.7928e-13
Lsclk25 sclk25 sclk25m 2.2185e-09
Rsclk25 sclk25m sclk26 0.01
CGsclk25 sclk26 0 1.7928e-13
Lsclk26 sclk26 sclk26m 2.2185e-09
Rsclk26 sclk26m sclk27 0.01
CGsclk26 sclk27 0 1.7928e-13
Lsclk27 sclk27 sclk27m 2.2185e-09
Rsclk27 sclk27m sclk28 0.01
CGsclk27 sclk28 0 1.7928e-13
Lsclk28 sclk28 sclk28m 2.2185e-09
Rsclk28 sclk28m sclk29 0.01
CGsclk28 sclk29 0 1.7928e-13
Lsclk29 sclk29 sclk29m 2.2185e-09
Rsclk29 sclk29m sclk30 0.01
CGsclk29 sclk30 0 1.7928e-13
Lsclk30 sclk30 sclk30m 2.2185e-09
Rsclk30 sclk30m sclk31 0.01
CGsclk30 sclk31 0 1.7928e-13
Lsclk31 sclk31 sclk31m 2.2185e-09
Rsclk31 sclk31m sclk32 0.01
CGsclk31 sclk32 0 1.7928e-13
Lsclk32 sclk32 sclk32m 2.2185e-09
Rsclk32 sclk32m sclk33 0.01
CGsclk32 sclk33 0 1.7928e-13
Lsclk33 sclk33 sclk33m 2.2185e-09
Rsclk33 sclk33m sclk34 0.01
CGsclk33 sclk34 0 1.7928e-13
Lsclk34 sclk34 sclk34m 2.2185e-09
Rsclk34 sclk34m sclk35 0.01
CGsclk34 sclk35 0 1.7928e-13
Lsclk35 sclk35 sclk35m 2.2185e-09
Rsclk35 sclk35m sclk36 0.01
CGsclk35 sclk36 0 1.7928e-13
Lsclk36 sclk36 sclk36m 2.2185e-09
Rsclk36 sclk36m sclk37 0.01
CGsclk36 sclk37 0 1.7928e-13
Lsclk37 sclk37 sclk37m 2.2185e-09
Rsclk37 sclk37m sclk38 0.01
CGsclk37 sclk38 0 1.7928e-13
Lsclk38 sclk38 sclk38m 2.2185e-09
Rsclk38 sclk38m sclk39 0.01
CGsclk38 sclk39 0 1.7928e-13
Lsclk39 sclk39 sclk39m 2.2185e-09
Rsclk39 sclk39m sclk40 0.01
CGsclk39 sclk40 0 1.7928e-13
Lmosi0 mosi0 mosi0m 2.7162e-09
Rmosi0 mosi0m mosi1 0.01
CGmosi0 mosi1 0 9.9294e-14
Lmosi1 mosi1 mosi1m 2.7162e-09
Rmosi1 mosi1m mosi2 0.01
CGmosi1 mosi2 0 9.9294e-14
Lmosi2 mosi2 mosi2m 2.7162e-09
Rmosi2 mosi2m mosi3 0.01
CGmosi2 mosi3 0 9.9294e-14
Lmosi3 mosi3 mosi3m 2.7162e-09
Rmosi3 mosi3m mosi4 0.01
CGmosi3 mosi4 0 9.9294e-14
Lmosi4 mosi4 mosi4m 2.7162e-09
Rmosi4 mosi4m mosi5 0.01
CGmosi4 mosi5 0 9.9294e-14
Lmosi5 mosi5 mosi5m 2.7162e-09
Rmosi5 mosi5m mosi6 0.01
CGmosi5 mosi6 0 9.9294e-14
Lmosi6 mosi6 mosi6m 2.7162e-09
Rmosi6 mosi6m mosi7 0.01
CGmosi6 mosi7 0 9.9294e-14
Lmosi7 mosi7 mosi7m 2.7162e-09
Rmosi7 mosi7m mosi8 0.01
CGmosi7 mosi8 0 9.9294e-14
Lmosi8 mosi8 mosi8m 2.7162e-09
Rmosi8 mosi8m mosi9 0.01
CGmosi8 mosi9 0 9.9294e-14
Lmosi9 mosi9 mosi9m 2.7162e-09
Rmosi9 mosi9m mosi10 0.01
CGmosi9 mosi10 0 9.9294e-14
Lmosi10 mosi10 mosi10m 2.7162e-09
Rmosi10 mosi10m mosi11 0.01
CGmosi10 mosi11 0 9.9294e-14
Lmosi11 mosi11 mosi11m 2.7162e-09
Rmosi11 mosi11m mosi12 0.01
CGmosi11 mosi12 0 9.9294e-14
Lmosi12 mosi12 mosi12m 2.7162e-09
Rmosi12 mosi12m mosi13 0.01
CGmosi12 mosi13 0 9.9294e-14
Lmosi13 mosi13 mosi13m 2.7162e-09
Rmosi13 mosi13m mosi14 0.01
CGmosi13 mosi14 0 9.9294e-14
Lmosi14 mosi14 mosi14m 2.7162e-09
Rmosi14 mosi14m mosi15 0.01
CGmosi14 mosi15 0 9.9294e-14
Lmosi15 mosi15 mosi15m 2.7162e-09
Rmosi15 mosi15m mosi16 0.01
CGmosi15 mosi16 0 9.9294e-14
Lmosi16 mosi16 mosi16m 2.7162e-09
Rmosi16 mosi16m mosi17 0.01
CGmosi16 mosi17 0 9.9294e-14
Lmosi17 mosi17 mosi17m 2.7162e-09
Rmosi17 mosi17m mosi18 0.01
CGmosi17 mosi18 0 9.9294e-14
Lmosi18 mosi18 mosi18m 2.7162e-09
Rmosi18 mosi18m mosi19 0.01
CGmosi18 mosi19 0 9.9294e-14
Lmosi19 mosi19 mosi19m 2.7162e-09
Rmosi19 mosi19m mosi20 0.01
CGmosi19 mosi20 0 9.9294e-14
Lmosi20 mosi20 mosi20m 2.7162e-09
Rmosi20 mosi20m mosi21 0.01
CGmosi20 mosi21 0 9.9294e-14
Lmosi21 mosi21 mosi21m 2.7162e-09
Rmosi21 mosi21m mosi22 0.01
CGmosi21 mosi22 0 9.9294e-14
Lmosi22 mosi22 mosi22m 2.7162e-09
Rmosi22 mosi22m mosi23 0.01
CGmosi22 mosi23 0 9.9294e-14
Lmosi23 mosi23 mosi23m 2.7162e-09
Rmosi23 mosi23m mosi24 0.01
CGmosi23 mosi24 0 9.9294e-14
Lmosi24 mosi24 mosi24m 2.7162e-09
Rmosi24 mosi24m mosi25 0.01
CGmosi24 mosi25 0 9.9294e-14
Lmosi25 mosi25 mosi25m 2.7162e-09
Rmosi25 mosi25m mosi26 0.01
CGmosi25 mosi26 0 9.9294e-14
Lmosi26 mosi26 mosi26m 2.7162e-09
Rmosi26 mosi26m mosi27 0.01
CGmosi26 mosi27 0 9.9294e-14
Lmosi27 mosi27 mosi27m 2.7162e-09
Rmosi27 mosi27m mosi28 0.01
CGmosi27 mosi28 0 9.9294e-14
Lmosi28 mosi28 mosi28m 2.7162e-09
Rmosi28 mosi28m mosi29 0.01
CGmosi28 mosi29 0 9.9294e-14
Lmosi29 mosi29 mosi29m 2.7162e-09
Rmosi29 mosi29m mosi30 0.01
CGmosi29 mosi30 0 9.9294e-14
Lmosi30 mosi30 mosi30m 2.7162e-09
Rmosi30 mosi30m mosi31 0.01
CGmosi30 mosi31 0 9.9294e-14
Lmosi31 mosi31 mosi31m 2.7162e-09
Rmosi31 mosi31m mosi32 0.01
CGmosi31 mosi32 0 9.9294e-14
Lmosi32 mosi32 mosi32m 2.7162e-09
Rmosi32 mosi32m mosi33 0.01
CGmosi32 mosi33 0 9.9294e-14
Lmosi33 mosi33 mosi33m 2.7162e-09
Rmosi33 mosi33m mosi34 0.01
CGmosi33 mosi34 0 9.9294e-14
Lmosi34 mosi34 mosi34m 2.7162e-09
Rmosi34 mosi34m mosi35 0.01
CGmosi34 mosi35 0 9.9294e-14
Lmosi35 mosi35 mosi35m 2.7162e-09
Rmosi35 mosi35m mosi36 0.01
CGmosi35 mosi36 0 9.9294e-14
Lmosi36 mosi36 mosi36m 2.7162e-09
Rmosi36 mosi36m mosi37 0.01
CGmosi36 mosi37 0 9.9294e-14
Lmosi37 mosi37 mosi37m 2.7162e-09
Rmosi37 mosi37m mosi38 0.01
CGmosi37 mosi38 0 9.9294e-14
Lmosi38 mosi38 mosi38m 2.7162e-09
Rmosi38 mosi38m mosi39 0.01
CGmosi38 mosi39 0 9.9294e-14
Lmosi39 mosi39 mosi39m 2.7162e-09
Rmosi39 mosi39m mosi40 0.01
CGmosi39 mosi40 0 9.9294e-14
Lcs0 cs0 cs0m 3.226e-09
Rcs0 cs0m cs1 0.01
CGcs0 cs1 0 3.5224e-14
Lcs1 cs1 cs1m 3.226e-09
Rcs1 cs1m cs2 0.01
CGcs1 cs2 0 3.5224e-14
Lcs2 cs2 cs2m 3.226e-09
Rcs2 cs2m cs3 0.01
CGcs2 cs3 0 3.5224e-14
Lcs3 cs3 cs3m 3.226e-09
Rcs3 cs3m cs4 0.01
CGcs3 cs4 0 3.5224e-14
Lcs4 cs4 cs4m 3.226e-09
Rcs4 cs4m cs5 0.01
CGcs4 cs5 0 3.5224e-14
Lcs5 cs5 cs5m 3.226e-09
Rcs5 cs5m cs6 0.01
CGcs5 cs6 0 3.5224e-14
Lcs6 cs6 cs6m 3.226e-09
Rcs6 cs6m cs7 0.01
CGcs6 cs7 0 3.5224e-14
Lcs7 cs7 cs7m 3.226e-09
Rcs7 cs7m cs8 0.01
CGcs7 cs8 0 3.5224e-14
Lcs8 cs8 cs8m 3.226e-09
Rcs8 cs8m cs9 0.01
CGcs8 cs9 0 3.5224e-14
Lcs9 cs9 cs9m 3.226e-09
Rcs9 cs9m cs10 0.01
CGcs9 cs10 0 3.5224e-14
Lcs10 cs10 cs10m 3.226e-09
Rcs10 cs10m cs11 0.01
CGcs10 cs11 0 3.5224e-14
Lcs11 cs11 cs11m 3.226e-09
Rcs11 cs11m cs12 0.01
CGcs11 cs12 0 3.5224e-14
Lcs12 cs12 cs12m 3.226e-09
Rcs12 cs12m cs13 0.01
CGcs12 cs13 0 3.5224e-14
Lcs13 cs13 cs13m 3.226e-09
Rcs13 cs13m cs14 0.01
CGcs13 cs14 0 3.5224e-14
Lcs14 cs14 cs14m 3.226e-09
Rcs14 cs14m cs15 0.01
CGcs14 cs15 0 3.5224e-14
Lcs15 cs15 cs15m 3.226e-09
Rcs15 cs15m cs16 0.01
CGcs15 cs16 0 3.5224e-14
Lcs16 cs16 cs16m 3.226e-09
Rcs16 cs16m cs17 0.01
CGcs16 cs17 0 3.5224e-14
Lcs17 cs17 cs17m 3.226e-09
Rcs17 cs17m cs18 0.01
CGcs17 cs18 0 3.5224e-14
Lcs18 cs18 cs18m 3.226e-09
Rcs18 cs18m cs19 0.01
CGcs18 cs19 0 3.5224e-14
Lcs19 cs19 cs19m 3.226e-09
Rcs19 cs19m cs20 0.01
CGcs19 cs20 0 3.5224e-14
Lcs20 cs20 cs20m 3.226e-09
Rcs20 cs20m cs21 0.01
CGcs20 cs21 0 3.5224e-14
Lcs21 cs21 cs21m 3.226e-09
Rcs21 cs21m cs22 0.01
CGcs21 cs22 0 3.5224e-14
Lcs22 cs22 cs22m 3.226e-09
Rcs22 cs22m cs23 0.01
CGcs22 cs23 0 3.5224e-14
Lcs23 cs23 cs23m 3.226e-09
Rcs23 cs23m cs24 0.01
CGcs23 cs24 0 3.5224e-14
Lcs24 cs24 cs24m 3.226e-09
Rcs24 cs24m cs25 0.01
CGcs24 cs25 0 3.5224e-14
Lcs25 cs25 cs25m 3.226e-09
Rcs25 cs25m cs26 0.01
CGcs25 cs26 0 3.5224e-14
Lcs26 cs26 cs26m 3.226e-09
Rcs26 cs26m cs27 0.01
CGcs26 cs27 0 3.5224e-14
Lcs27 cs27 cs27m 3.226e-09
Rcs27 cs27m cs28 0.01
CGcs27 cs28 0 3.5224e-14
Lcs28 cs28 cs28m 3.226e-09
Rcs28 cs28m cs29 0.01
CGcs28 cs29 0 3.5224e-14
Lcs29 cs29 cs29m 3.226e-09
Rcs29 cs29m cs30 0.01
CGcs29 cs30 0 3.5224e-14
Lcs30 cs30 cs30m 3.226e-09
Rcs30 cs30m cs31 0.01
CGcs30 cs31 0 3.5224e-14
Lcs31 cs31 cs31m 3.226e-09
Rcs31 cs31m cs32 0.01
CGcs31 cs32 0 3.5224e-14
Lcs32 cs32 cs32m 3.226e-09
Rcs32 cs32m cs33 0.01
CGcs32 cs33 0 3.5224e-14
Lcs33 cs33 cs33m 3.226e-09
Rcs33 cs33m cs34 0.01
CGcs33 cs34 0 3.5224e-14
Lcs34 cs34 cs34m 3.226e-09
Rcs34 cs34m cs35 0.01
CGcs34 cs35 0 3.5224e-14
Lcs35 cs35 cs35m 3.226e-09
Rcs35 cs35m cs36 0.01
CGcs35 cs36 0 3.5224e-14
Lcs36 cs36 cs36m 3.226e-09
Rcs36 cs36m cs37 0.01
CGcs36 cs37 0 3.5224e-14
Lcs37 cs37 cs37m 3.226e-09
Rcs37 cs37m cs38 0.01
CGcs37 cs38 0 3.5224e-14
Lcs38 cs38 cs38m 3.226e-09
Rcs38 cs38m cs39 0.01
CGcs38 cs39 0 3.5224e-14
Lcs39 cs39 cs39m 3.226e-09
Rcs39 cs39m cs40 0.01
CGcs39 cs40 0 3.5224e-14
Ldc0 dc0 dc0m 3.2287e-09
Rdc0 dc0m dc1 0.01
CGdc0 dc1 0 1.0574e-13
Ldc1 dc1 dc1m 3.2287e-09
Rdc1 dc1m dc2 0.01
CGdc1 dc2 0 1.0574e-13
Ldc2 dc2 dc2m 3.2287e-09
Rdc2 dc2m dc3 0.01
CGdc2 dc3 0 1.0574e-13
Ldc3 dc3 dc3m 3.2287e-09
Rdc3 dc3m dc4 0.01
CGdc3 dc4 0 1.0574e-13
Ldc4 dc4 dc4m 3.2287e-09
Rdc4 dc4m dc5 0.01
CGdc4 dc5 0 1.0574e-13
Ldc5 dc5 dc5m 3.2287e-09
Rdc5 dc5m dc6 0.01
CGdc5 dc6 0 1.0574e-13
Ldc6 dc6 dc6m 3.2287e-09
Rdc6 dc6m dc7 0.01
CGdc6 dc7 0 1.0574e-13
Ldc7 dc7 dc7m 3.2287e-09
Rdc7 dc7m dc8 0.01
CGdc7 dc8 0 1.0574e-13
Ldc8 dc8 dc8m 3.2287e-09
Rdc8 dc8m dc9 0.01
CGdc8 dc9 0 1.0574e-13
Ldc9 dc9 dc9m 3.2287e-09
Rdc9 dc9m dc10 0.01
CGdc9 dc10 0 1.0574e-13
Ldc10 dc10 dc10m 3.2287e-09
Rdc10 dc10m dc11 0.01
CGdc10 dc11 0 1.0574e-13
Ldc11 dc11 dc11m 3.2287e-09
Rdc11 dc11m dc12 0.01
CGdc11 dc12 0 1.0574e-13
Ldc12 dc12 dc12m 3.2287e-09
Rdc12 dc12m dc13 0.01
CGdc12 dc13 0 1.0574e-13
Ldc13 dc13 dc13m 3.2287e-09
Rdc13 dc13m dc14 0.01
CGdc13 dc14 0 1.0574e-13
Ldc14 dc14 dc14m 3.2287e-09
Rdc14 dc14m dc15 0.01
CGdc14 dc15 0 1.0574e-13
Ldc15 dc15 dc15m 3.2287e-09
Rdc15 dc15m dc16 0.01
CGdc15 dc16 0 1.0574e-13
Ldc16 dc16 dc16m 3.2287e-09
Rdc16 dc16m dc17 0.01
CGdc16 dc17 0 1.0574e-13
Ldc17 dc17 dc17m 3.2287e-09
Rdc17 dc17m dc18 0.01
CGdc17 dc18 0 1.0574e-13
Ldc18 dc18 dc18m 3.2287e-09
Rdc18 dc18m dc19 0.01
CGdc18 dc19 0 1.0574e-13
Ldc19 dc19 dc19m 3.2287e-09
Rdc19 dc19m dc20 0.01
CGdc19 dc20 0 1.0574e-13
Ldc20 dc20 dc20m 3.2287e-09
Rdc20 dc20m dc21 0.01
CGdc20 dc21 0 1.0574e-13
Ldc21 dc21 dc21m 3.2287e-09
Rdc21 dc21m dc22 0.01
CGdc21 dc22 0 1.0574e-13
Ldc22 dc22 dc22m 3.2287e-09
Rdc22 dc22m dc23 0.01
CGdc22 dc23 0 1.0574e-13
Ldc23 dc23 dc23m 3.2287e-09
Rdc23 dc23m dc24 0.01
CGdc23 dc24 0 1.0574e-13
Ldc24 dc24 dc24m 3.2287e-09
Rdc24 dc24m dc25 0.01
CGdc24 dc25 0 1.0574e-13
Ldc25 dc25 dc25m 3.2287e-09
Rdc25 dc25m dc26 0.01
CGdc25 dc26 0 1.0574e-13
Ldc26 dc26 dc26m 3.2287e-09
Rdc26 dc26m dc27 0.01
CGdc26 dc27 0 1.0574e-13
Ldc27 dc27 dc27m 3.2287e-09
Rdc27 dc27m dc28 0.01
CGdc27 dc28 0 1.0574e-13
Ldc28 dc28 dc28m 3.2287e-09
Rdc28 dc28m dc29 0.01
CGdc28 dc29 0 1.0574e-13
Ldc29 dc29 dc29m 3.2287e-09
Rdc29 dc29m dc30 0.01
CGdc29 dc30 0 1.0574e-13
Ldc30 dc30 dc30m 3.2287e-09
Rdc30 dc30m dc31 0.01
CGdc30 dc31 0 1.0574e-13
Ldc31 dc31 dc31m 3.2287e-09
Rdc31 dc31m dc32 0.01
CGdc31 dc32 0 1.0574e-13
Ldc32 dc32 dc32m 3.2287e-09
Rdc32 dc32m dc33 0.01
CGdc32 dc33 0 1.0574e-13
Ldc33 dc33 dc33m 3.2287e-09
Rdc33 dc33m dc34 0.01
CGdc33 dc34 0 1.0574e-13
Ldc34 dc34 dc34m 3.2287e-09
Rdc34 dc34m dc35 0.01
CGdc34 dc35 0 1.0574e-13
Ldc35 dc35 dc35m 3.2287e-09
Rdc35 dc35m dc36 0.01
CGdc35 dc36 0 1.0574e-13
Ldc36 dc36 dc36m 3.2287e-09
Rdc36 dc36m dc37 0.01
CGdc36 dc37 0 1.0574e-13
Ldc37 dc37 dc37m 3.2287e-09
Rdc37 dc37m dc38 0.01
CGdc37 dc38 0 1.0574e-13
Ldc38 dc38 dc38m 3.2287e-09
Rdc38 dc38m dc39 0.01
CGdc38 dc39 0 1.0574e-13
Ldc39 dc39 dc39m 3.2287e-09
Rdc39 dc39m dc40 0.01
CGdc39 dc40 0 1.0574e-13
Ksclkmosi0 Lsclk0 Lmosi0 0.09199
CMsclkmosi0 sclk1 mosi1 8.4121e-15
Ksclkmosi1 Lsclk1 Lmosi1 0.09199
CMsclkmosi1 sclk2 mosi2 8.4121e-15
Ksclkmosi2 Lsclk2 Lmosi2 0.09199
CMsclkmosi2 sclk3 mosi3 8.4121e-15
Ksclkmosi3 Lsclk3 Lmosi3 0.09199
CMsclkmosi3 sclk4 mosi4 8.4121e-15
Ksclkmosi4 Lsclk4 Lmosi4 0.09199
CMsclkmosi4 sclk5 mosi5 8.4121e-15
Ksclkmosi5 Lsclk5 Lmosi5 0.09199
CMsclkmosi5 sclk6 mosi6 8.4121e-15
Ksclkmosi6 Lsclk6 Lmosi6 0.09199
CMsclkmosi6 sclk7 mosi7 8.4121e-15
Ksclkmosi7 Lsclk7 Lmosi7 0.09199
CMsclkmosi7 sclk8 mosi8 8.4121e-15
Ksclkmosi8 Lsclk8 Lmosi8 0.09199
CMsclkmosi8 sclk9 mosi9 8.4121e-15
Ksclkmosi9 Lsclk9 Lmosi9 0.09199
CMsclkmosi9 sclk10 mosi10 8.4121e-15
Ksclkmosi10 Lsclk10 Lmosi10 0.09199
CMsclkmosi10 sclk11 mosi11 8.4121e-15
Ksclkmosi11 Lsclk11 Lmosi11 0.09199
CMsclkmosi11 sclk12 mosi12 8.4121e-15
Ksclkmosi12 Lsclk12 Lmosi12 0.09199
CMsclkmosi12 sclk13 mosi13 8.4121e-15
Ksclkmosi13 Lsclk13 Lmosi13 0.09199
CMsclkmosi13 sclk14 mosi14 8.4121e-15
Ksclkmosi14 Lsclk14 Lmosi14 0.09199
CMsclkmosi14 sclk15 mosi15 8.4121e-15
Ksclkmosi15 Lsclk15 Lmosi15 0.09199
CMsclkmosi15 sclk16 mosi16 8.4121e-15
Ksclkmosi16 Lsclk16 Lmosi16 0.09199
CMsclkmosi16 sclk17 mosi17 8.4121e-15
Ksclkmosi17 Lsclk17 Lmosi17 0.09199
CMsclkmosi17 sclk18 mosi18 8.4121e-15
Ksclkmosi18 Lsclk18 Lmosi18 0.09199
CMsclkmosi18 sclk19 mosi19 8.4121e-15
Ksclkmosi19 Lsclk19 Lmosi19 0.09199
CMsclkmosi19 sclk20 mosi20 8.4121e-15
Ksclkmosi20 Lsclk20 Lmosi20 0.09199
CMsclkmosi20 sclk21 mosi21 8.4121e-15
Ksclkmosi21 Lsclk21 Lmosi21 0.09199
CMsclkmosi21 sclk22 mosi22 8.4121e-15
Ksclkmosi22 Lsclk22 Lmosi22 0.09199
CMsclkmosi22 sclk23 mosi23 8.4121e-15
Ksclkmosi23 Lsclk23 Lmosi23 0.09199
CMsclkmosi23 sclk24 mosi24 8.4121e-15
Ksclkmosi24 Lsclk24 Lmosi24 0.09199
CMsclkmosi24 sclk25 mosi25 8.4121e-15
Ksclkmosi25 Lsclk25 Lmosi25 0.09199
CMsclkmosi25 sclk26 mosi26 8.4121e-15
Ksclkmosi26 Lsclk26 Lmosi26 0.09199
CMsclkmosi26 sclk27 mosi27 8.4121e-15
Ksclkmosi27 Lsclk27 Lmosi27 0.09199
CMsclkmosi27 sclk28 mosi28 8.4121e-15
Ksclkmosi28 Lsclk28 Lmosi28 0.09199
CMsclkmosi28 sclk29 mosi29 8.4121e-15
Ksclkmosi29 Lsclk29 Lmosi29 0.09199
CMsclkmosi29 sclk30 mosi30 8.4121e-15
Ksclkmosi30 Lsclk30 Lmosi30 0.09199
CMsclkmosi30 sclk31 mosi31 8.4121e-15
Ksclkmosi31 Lsclk31 Lmosi31 0.09199
CMsclkmosi31 sclk32 mosi32 8.4121e-15
Ksclkmosi32 Lsclk32 Lmosi32 0.09199
CMsclkmosi32 sclk33 mosi33 8.4121e-15
Ksclkmosi33 Lsclk33 Lmosi33 0.09199
CMsclkmosi33 sclk34 mosi34 8.4121e-15
Ksclkmosi34 Lsclk34 Lmosi34 0.09199
CMsclkmosi34 sclk35 mosi35 8.4121e-15
Ksclkmosi35 Lsclk35 Lmosi35 0.09199
CMsclkmosi35 sclk36 mosi36 8.4121e-15
Ksclkmosi36 Lsclk36 Lmosi36 0.09199
CMsclkmosi36 sclk37 mosi37 8.4121e-15
Ksclkmosi37 Lsclk37 Lmosi37 0.09199
CMsclkmosi37 sclk38 mosi38 8.4121e-15
Ksclkmosi38 Lsclk38 Lmosi38 0.09199
CMsclkmosi38 sclk39 mosi39 8.4121e-15
Ksclkmosi39 Lsclk39 Lmosi39 0.09199
CMsclkmosi39 sclk40 mosi40 8.4121e-15
Ksclkcs0 Lsclk0 Lcs0 0.07649
CMsclkcs0 sclk1 cs1 3.5458e-15
Ksclkcs1 Lsclk1 Lcs1 0.07649
CMsclkcs1 sclk2 cs2 3.5458e-15
Ksclkcs2 Lsclk2 Lcs2 0.07649
CMsclkcs2 sclk3 cs3 3.5458e-15
Ksclkcs3 Lsclk3 Lcs3 0.07649
CMsclkcs3 sclk4 cs4 3.5458e-15
Ksclkcs4 Lsclk4 Lcs4 0.07649
CMsclkcs4 sclk5 cs5 3.5458e-15
Ksclkcs5 Lsclk5 Lcs5 0.07649
CMsclkcs5 sclk6 cs6 3.5458e-15
Ksclkcs6 Lsclk6 Lcs6 0.07649
CMsclkcs6 sclk7 cs7 3.5458e-15
Ksclkcs7 Lsclk7 Lcs7 0.07649
CMsclkcs7 sclk8 cs8 3.5458e-15
Ksclkcs8 Lsclk8 Lcs8 0.07649
CMsclkcs8 sclk9 cs9 3.5458e-15
Ksclkcs9 Lsclk9 Lcs9 0.07649
CMsclkcs9 sclk10 cs10 3.5458e-15
Ksclkcs10 Lsclk10 Lcs10 0.07649
CMsclkcs10 sclk11 cs11 3.5458e-15
Ksclkcs11 Lsclk11 Lcs11 0.07649
CMsclkcs11 sclk12 cs12 3.5458e-15
Ksclkcs12 Lsclk12 Lcs12 0.07649
CMsclkcs12 sclk13 cs13 3.5458e-15
Ksclkcs13 Lsclk13 Lcs13 0.07649
CMsclkcs13 sclk14 cs14 3.5458e-15
Ksclkcs14 Lsclk14 Lcs14 0.07649
CMsclkcs14 sclk15 cs15 3.5458e-15
Ksclkcs15 Lsclk15 Lcs15 0.07649
CMsclkcs15 sclk16 cs16 3.5458e-15
Ksclkcs16 Lsclk16 Lcs16 0.07649
CMsclkcs16 sclk17 cs17 3.5458e-15
Ksclkcs17 Lsclk17 Lcs17 0.07649
CMsclkcs17 sclk18 cs18 3.5458e-15
Ksclkcs18 Lsclk18 Lcs18 0.07649
CMsclkcs18 sclk19 cs19 3.5458e-15
Ksclkcs19 Lsclk19 Lcs19 0.07649
CMsclkcs19 sclk20 cs20 3.5458e-15
Ksclkcs20 Lsclk20 Lcs20 0.07649
CMsclkcs20 sclk21 cs21 3.5458e-15
Ksclkcs21 Lsclk21 Lcs21 0.07649
CMsclkcs21 sclk22 cs22 3.5458e-15
Ksclkcs22 Lsclk22 Lcs22 0.07649
CMsclkcs22 sclk23 cs23 3.5458e-15
Ksclkcs23 Lsclk23 Lcs23 0.07649
CMsclkcs23 sclk24 cs24 3.5458e-15
Ksclkcs24 Lsclk24 Lcs24 0.07649
CMsclkcs24 sclk25 cs25 3.5458e-15
Ksclkcs25 Lsclk25 Lcs25 0.07649
CMsclkcs25 sclk26 cs26 3.5458e-15
Ksclkcs26 Lsclk26 Lcs26 0.07649
CMsclkcs26 sclk27 cs27 3.5458e-15
Ksclkcs27 Lsclk27 Lcs27 0.07649
CMsclkcs27 sclk28 cs28 3.5458e-15
Ksclkcs28 Lsclk28 Lcs28 0.07649
CMsclkcs28 sclk29 cs29 3.5458e-15
Ksclkcs29 Lsclk29 Lcs29 0.07649
CMsclkcs29 sclk30 cs30 3.5458e-15
Ksclkcs30 Lsclk30 Lcs30 0.07649
CMsclkcs30 sclk31 cs31 3.5458e-15
Ksclkcs31 Lsclk31 Lcs31 0.07649
CMsclkcs31 sclk32 cs32 3.5458e-15
Ksclkcs32 Lsclk32 Lcs32 0.07649
CMsclkcs32 sclk33 cs33 3.5458e-15
Ksclkcs33 Lsclk33 Lcs33 0.07649
CMsclkcs33 sclk34 cs34 3.5458e-15
Ksclkcs34 Lsclk34 Lcs34 0.07649
CMsclkcs34 sclk35 cs35 3.5458e-15
Ksclkcs35 Lsclk35 Lcs35 0.07649
CMsclkcs35 sclk36 cs36 3.5458e-15
Ksclkcs36 Lsclk36 Lcs36 0.07649
CMsclkcs36 sclk37 cs37 3.5458e-15
Ksclkcs37 Lsclk37 Lcs37 0.07649
CMsclkcs37 sclk38 cs38 3.5458e-15
Ksclkcs38 Lsclk38 Lcs38 0.07649
CMsclkcs38 sclk39 cs39 3.5458e-15
Ksclkcs39 Lsclk39 Lcs39 0.07649
CMsclkcs39 sclk40 cs40 3.5458e-15
Ksclkdc0 Lsclk0 Ldc0 0.05966
CMsclkdc0 sclk1 dc1 2.0228e-15
Ksclkdc1 Lsclk1 Ldc1 0.05966
CMsclkdc1 sclk2 dc2 2.0228e-15
Ksclkdc2 Lsclk2 Ldc2 0.05966
CMsclkdc2 sclk3 dc3 2.0228e-15
Ksclkdc3 Lsclk3 Ldc3 0.05966
CMsclkdc3 sclk4 dc4 2.0228e-15
Ksclkdc4 Lsclk4 Ldc4 0.05966
CMsclkdc4 sclk5 dc5 2.0228e-15
Ksclkdc5 Lsclk5 Ldc5 0.05966
CMsclkdc5 sclk6 dc6 2.0228e-15
Ksclkdc6 Lsclk6 Ldc6 0.05966
CMsclkdc6 sclk7 dc7 2.0228e-15
Ksclkdc7 Lsclk7 Ldc7 0.05966
CMsclkdc7 sclk8 dc8 2.0228e-15
Ksclkdc8 Lsclk8 Ldc8 0.05966
CMsclkdc8 sclk9 dc9 2.0228e-15
Ksclkdc9 Lsclk9 Ldc9 0.05966
CMsclkdc9 sclk10 dc10 2.0228e-15
Ksclkdc10 Lsclk10 Ldc10 0.05966
CMsclkdc10 sclk11 dc11 2.0228e-15
Ksclkdc11 Lsclk11 Ldc11 0.05966
CMsclkdc11 sclk12 dc12 2.0228e-15
Ksclkdc12 Lsclk12 Ldc12 0.05966
CMsclkdc12 sclk13 dc13 2.0228e-15
Ksclkdc13 Lsclk13 Ldc13 0.05966
CMsclkdc13 sclk14 dc14 2.0228e-15
Ksclkdc14 Lsclk14 Ldc14 0.05966
CMsclkdc14 sclk15 dc15 2.0228e-15
Ksclkdc15 Lsclk15 Ldc15 0.05966
CMsclkdc15 sclk16 dc16 2.0228e-15
Ksclkdc16 Lsclk16 Ldc16 0.05966
CMsclkdc16 sclk17 dc17 2.0228e-15
Ksclkdc17 Lsclk17 Ldc17 0.05966
CMsclkdc17 sclk18 dc18 2.0228e-15
Ksclkdc18 Lsclk18 Ldc18 0.05966
CMsclkdc18 sclk19 dc19 2.0228e-15
Ksclkdc19 Lsclk19 Ldc19 0.05966
CMsclkdc19 sclk20 dc20 2.0228e-15
Ksclkdc20 Lsclk20 Ldc20 0.05966
CMsclkdc20 sclk21 dc21 2.0228e-15
Ksclkdc21 Lsclk21 Ldc21 0.05966
CMsclkdc21 sclk22 dc22 2.0228e-15
Ksclkdc22 Lsclk22 Ldc22 0.05966
CMsclkdc22 sclk23 dc23 2.0228e-15
Ksclkdc23 Lsclk23 Ldc23 0.05966
CMsclkdc23 sclk24 dc24 2.0228e-15
Ksclkdc24 Lsclk24 Ldc24 0.05966
CMsclkdc24 sclk25 dc25 2.0228e-15
Ksclkdc25 Lsclk25 Ldc25 0.05966
CMsclkdc25 sclk26 dc26 2.0228e-15
Ksclkdc26 Lsclk26 Ldc26 0.05966
CMsclkdc26 sclk27 dc27 2.0228e-15
Ksclkdc27 Lsclk27 Ldc27 0.05966
CMsclkdc27 sclk28 dc28 2.0228e-15
Ksclkdc28 Lsclk28 Ldc28 0.05966
CMsclkdc28 sclk29 dc29 2.0228e-15
Ksclkdc29 Lsclk29 Ldc29 0.05966
CMsclkdc29 sclk30 dc30 2.0228e-15
Ksclkdc30 Lsclk30 Ldc30 0.05966
CMsclkdc30 sclk31 dc31 2.0228e-15
Ksclkdc31 Lsclk31 Ldc31 0.05966
CMsclkdc31 sclk32 dc32 2.0228e-15
Ksclkdc32 Lsclk32 Ldc32 0.05966
CMsclkdc32 sclk33 dc33 2.0228e-15
Ksclkdc33 Lsclk33 Ldc33 0.05966
CMsclkdc33 sclk34 dc34 2.0228e-15
Ksclkdc34 Lsclk34 Ldc34 0.05966
CMsclkdc34 sclk35 dc35 2.0228e-15
Ksclkdc35 Lsclk35 Ldc35 0.05966
CMsclkdc35 sclk36 dc36 2.0228e-15
Ksclkdc36 Lsclk36 Ldc36 0.05966
CMsclkdc36 sclk37 dc37 2.0228e-15
Ksclkdc37 Lsclk37 Ldc37 0.05966
CMsclkdc37 sclk38 dc38 2.0228e-15
Ksclkdc38 Lsclk38 Ldc38 0.05966
CMsclkdc38 sclk39 dc39 2.0228e-15
Ksclkdc39 Lsclk39 Ldc39 0.05966
CMsclkdc39 sclk40 dc40 2.0228e-15
Kmosics0 Lmosi0 Lcs0 0.42825
CMmosics0 mosi1 cs1 7.7323e-14
Kmosics1 Lmosi1 Lcs1 0.42825
CMmosics1 mosi2 cs2 7.7323e-14
Kmosics2 Lmosi2 Lcs2 0.42825
CMmosics2 mosi3 cs3 7.7323e-14
Kmosics3 Lmosi3 Lcs3 0.42825
CMmosics3 mosi4 cs4 7.7323e-14
Kmosics4 Lmosi4 Lcs4 0.42825
CMmosics4 mosi5 cs5 7.7323e-14
Kmosics5 Lmosi5 Lcs5 0.42825
CMmosics5 mosi6 cs6 7.7323e-14
Kmosics6 Lmosi6 Lcs6 0.42825
CMmosics6 mosi7 cs7 7.7323e-14
Kmosics7 Lmosi7 Lcs7 0.42825
CMmosics7 mosi8 cs8 7.7323e-14
Kmosics8 Lmosi8 Lcs8 0.42825
CMmosics8 mosi9 cs9 7.7323e-14
Kmosics9 Lmosi9 Lcs9 0.42825
CMmosics9 mosi10 cs10 7.7323e-14
Kmosics10 Lmosi10 Lcs10 0.42825
CMmosics10 mosi11 cs11 7.7323e-14
Kmosics11 Lmosi11 Lcs11 0.42825
CMmosics11 mosi12 cs12 7.7323e-14
Kmosics12 Lmosi12 Lcs12 0.42825
CMmosics12 mosi13 cs13 7.7323e-14
Kmosics13 Lmosi13 Lcs13 0.42825
CMmosics13 mosi14 cs14 7.7323e-14
Kmosics14 Lmosi14 Lcs14 0.42825
CMmosics14 mosi15 cs15 7.7323e-14
Kmosics15 Lmosi15 Lcs15 0.42825
CMmosics15 mosi16 cs16 7.7323e-14
Kmosics16 Lmosi16 Lcs16 0.42825
CMmosics16 mosi17 cs17 7.7323e-14
Kmosics17 Lmosi17 Lcs17 0.42825
CMmosics17 mosi18 cs18 7.7323e-14
Kmosics18 Lmosi18 Lcs18 0.42825
CMmosics18 mosi19 cs19 7.7323e-14
Kmosics19 Lmosi19 Lcs19 0.42825
CMmosics19 mosi20 cs20 7.7323e-14
Kmosics20 Lmosi20 Lcs20 0.42825
CMmosics20 mosi21 cs21 7.7323e-14
Kmosics21 Lmosi21 Lcs21 0.42825
CMmosics21 mosi22 cs22 7.7323e-14
Kmosics22 Lmosi22 Lcs22 0.42825
CMmosics22 mosi23 cs23 7.7323e-14
Kmosics23 Lmosi23 Lcs23 0.42825
CMmosics23 mosi24 cs24 7.7323e-14
Kmosics24 Lmosi24 Lcs24 0.42825
CMmosics24 mosi25 cs25 7.7323e-14
Kmosics25 Lmosi25 Lcs25 0.42825
CMmosics25 mosi26 cs26 7.7323e-14
Kmosics26 Lmosi26 Lcs26 0.42825
CMmosics26 mosi27 cs27 7.7323e-14
Kmosics27 Lmosi27 Lcs27 0.42825
CMmosics27 mosi28 cs28 7.7323e-14
Kmosics28 Lmosi28 Lcs28 0.42825
CMmosics28 mosi29 cs29 7.7323e-14
Kmosics29 Lmosi29 Lcs29 0.42825
CMmosics29 mosi30 cs30 7.7323e-14
Kmosics30 Lmosi30 Lcs30 0.42825
CMmosics30 mosi31 cs31 7.7323e-14
Kmosics31 Lmosi31 Lcs31 0.42825
CMmosics31 mosi32 cs32 7.7323e-14
Kmosics32 Lmosi32 Lcs32 0.42825
CMmosics32 mosi33 cs33 7.7323e-14
Kmosics33 Lmosi33 Lcs33 0.42825
CMmosics33 mosi34 cs34 7.7323e-14
Kmosics34 Lmosi34 Lcs34 0.42825
CMmosics34 mosi35 cs35 7.7323e-14
Kmosics35 Lmosi35 Lcs35 0.42825
CMmosics35 mosi36 cs36 7.7323e-14
Kmosics36 Lmosi36 Lcs36 0.42825
CMmosics36 mosi37 cs37 7.7323e-14
Kmosics37 Lmosi37 Lcs37 0.42825
CMmosics37 mosi38 cs38 7.7323e-14
Kmosics38 Lmosi38 Lcs38 0.42825
CMmosics38 mosi39 cs39 7.7323e-14
Kmosics39 Lmosi39 Lcs39 0.42825
CMmosics39 mosi40 cs40 7.7323e-14
Kmosidc0 Lmosi0 Ldc0 0.26340
CMmosidc0 mosi1 dc1 8.3435e-15
Kmosidc1 Lmosi1 Ldc1 0.26340
CMmosidc1 mosi2 dc2 8.3435e-15
Kmosidc2 Lmosi2 Ldc2 0.26340
CMmosidc2 mosi3 dc3 8.3435e-15
Kmosidc3 Lmosi3 Ldc3 0.26340
CMmosidc3 mosi4 dc4 8.3435e-15
Kmosidc4 Lmosi4 Ldc4 0.26340
CMmosidc4 mosi5 dc5 8.3435e-15
Kmosidc5 Lmosi5 Ldc5 0.26340
CMmosidc5 mosi6 dc6 8.3435e-15
Kmosidc6 Lmosi6 Ldc6 0.26340
CMmosidc6 mosi7 dc7 8.3435e-15
Kmosidc7 Lmosi7 Ldc7 0.26340
CMmosidc7 mosi8 dc8 8.3435e-15
Kmosidc8 Lmosi8 Ldc8 0.26340
CMmosidc8 mosi9 dc9 8.3435e-15
Kmosidc9 Lmosi9 Ldc9 0.26340
CMmosidc9 mosi10 dc10 8.3435e-15
Kmosidc10 Lmosi10 Ldc10 0.26340
CMmosidc10 mosi11 dc11 8.3435e-15
Kmosidc11 Lmosi11 Ldc11 0.26340
CMmosidc11 mosi12 dc12 8.3435e-15
Kmosidc12 Lmosi12 Ldc12 0.26340
CMmosidc12 mosi13 dc13 8.3435e-15
Kmosidc13 Lmosi13 Ldc13 0.26340
CMmosidc13 mosi14 dc14 8.3435e-15
Kmosidc14 Lmosi14 Ldc14 0.26340
CMmosidc14 mosi15 dc15 8.3435e-15
Kmosidc15 Lmosi15 Ldc15 0.26340
CMmosidc15 mosi16 dc16 8.3435e-15
Kmosidc16 Lmosi16 Ldc16 0.26340
CMmosidc16 mosi17 dc17 8.3435e-15
Kmosidc17 Lmosi17 Ldc17 0.26340
CMmosidc17 mosi18 dc18 8.3435e-15
Kmosidc18 Lmosi18 Ldc18 0.26340
CMmosidc18 mosi19 dc19 8.3435e-15
Kmosidc19 Lmosi19 Ldc19 0.26340
CMmosidc19 mosi20 dc20 8.3435e-15
Kmosidc20 Lmosi20 Ldc20 0.26340
CMmosidc20 mosi21 dc21 8.3435e-15
Kmosidc21 Lmosi21 Ldc21 0.26340
CMmosidc21 mosi22 dc22 8.3435e-15
Kmosidc22 Lmosi22 Ldc22 0.26340
CMmosidc22 mosi23 dc23 8.3435e-15
Kmosidc23 Lmosi23 Ldc23 0.26340
CMmosidc23 mosi24 dc24 8.3435e-15
Kmosidc24 Lmosi24 Ldc24 0.26340
CMmosidc24 mosi25 dc25 8.3435e-15
Kmosidc25 Lmosi25 Ldc25 0.26340
CMmosidc25 mosi26 dc26 8.3435e-15
Kmosidc26 Lmosi26 Ldc26 0.26340
CMmosidc26 mosi27 dc27 8.3435e-15
Kmosidc27 Lmosi27 Ldc27 0.26340
CMmosidc27 mosi28 dc28 8.3435e-15
Kmosidc28 Lmosi28 Ldc28 0.26340
CMmosidc28 mosi29 dc29 8.3435e-15
Kmosidc29 Lmosi29 Ldc29 0.26340
CMmosidc29 mosi30 dc30 8.3435e-15
Kmosidc30 Lmosi30 Ldc30 0.26340
CMmosidc30 mosi31 dc31 8.3435e-15
Kmosidc31 Lmosi31 Ldc31 0.26340
CMmosidc31 mosi32 dc32 8.3435e-15
Kmosidc32 Lmosi32 Ldc32 0.26340
CMmosidc32 mosi33 dc33 8.3435e-15
Kmosidc33 Lmosi33 Ldc33 0.26340
CMmosidc33 mosi34 dc34 8.3435e-15
Kmosidc34 Lmosi34 Ldc34 0.26340
CMmosidc34 mosi35 dc35 8.3435e-15
Kmosidc35 Lmosi35 Ldc35 0.26340
CMmosidc35 mosi36 dc36 8.3435e-15
Kmosidc36 Lmosi36 Ldc36 0.26340
CMmosidc36 mosi37 dc37 8.3435e-15
Kmosidc37 Lmosi37 Ldc37 0.26340
CMmosidc37 mosi38 dc38 8.3435e-15
Kmosidc38 Lmosi38 Ldc38 0.26340
CMmosidc38 mosi39 dc39 8.3435e-15
Kmosidc39 Lmosi39 Ldc39 0.26340
CMmosidc39 mosi40 dc40 8.3435e-15
Kcsdc0 Lcs0 Ldc0 0.46507
CMcsdc0 cs1 dc1 7.7304e-14
Kcsdc1 Lcs1 Ldc1 0.46507
CMcsdc1 cs2 dc2 7.7304e-14
Kcsdc2 Lcs2 Ldc2 0.46507
CMcsdc2 cs3 dc3 7.7304e-14
Kcsdc3 Lcs3 Ldc3 0.46507
CMcsdc3 cs4 dc4 7.7304e-14
Kcsdc4 Lcs4 Ldc4 0.46507
CMcsdc4 cs5 dc5 7.7304e-14
Kcsdc5 Lcs5 Ldc5 0.46507
CMcsdc5 cs6 dc6 7.7304e-14
Kcsdc6 Lcs6 Ldc6 0.46507
CMcsdc6 cs7 dc7 7.7304e-14
Kcsdc7 Lcs7 Ldc7 0.46507
CMcsdc7 cs8 dc8 7.7304e-14
Kcsdc8 Lcs8 Ldc8 0.46507
CMcsdc8 cs9 dc9 7.7304e-14
Kcsdc9 Lcs9 Ldc9 0.46507
CMcsdc9 cs10 dc10 7.7304e-14
Kcsdc10 Lcs10 Ldc10 0.46507
CMcsdc10 cs11 dc11 7.7304e-14
Kcsdc11 Lcs11 Ldc11 0.46507
CMcsdc11 cs12 dc12 7.7304e-14
Kcsdc12 Lcs12 Ldc12 0.46507
CMcsdc12 cs13 dc13 7.7304e-14
Kcsdc13 Lcs13 Ldc13 0.46507
CMcsdc13 cs14 dc14 7.7304e-14
Kcsdc14 Lcs14 Ldc14 0.46507
CMcsdc14 cs15 dc15 7.7304e-14
Kcsdc15 Lcs15 Ldc15 0.46507
CMcsdc15 cs16 dc16 7.7304e-14
Kcsdc16 Lcs16 Ldc16 0.46507
CMcsdc16 cs17 dc17 7.7304e-14
Kcsdc17 Lcs17 Ldc17 0.46507
CMcsdc17 cs18 dc18 7.7304e-14
Kcsdc18 Lcs18 Ldc18 0.46507
CMcsdc18 cs19 dc19 7.7304e-14
Kcsdc19 Lcs19 Ldc19 0.46507
CMcsdc19 cs20 dc20 7.7304e-14
Kcsdc20 Lcs20 Ldc20 0.46507
CMcsdc20 cs21 dc21 7.7304e-14
Kcsdc21 Lcs21 Ldc21 0.46507
CMcsdc21 cs22 dc22 7.7304e-14
Kcsdc22 Lcs22 Ldc22 0.46507
CMcsdc22 cs23 dc23 7.7304e-14
Kcsdc23 Lcs23 Ldc23 0.46507
CMcsdc23 cs24 dc24 7.7304e-14
Kcsdc24 Lcs24 Ldc24 0.46507
CMcsdc24 cs25 dc25 7.7304e-14
Kcsdc25 Lcs25 Ldc25 0.46507
CMcsdc25 cs26 dc26 7.7304e-14
Kcsdc26 Lcs26 Ldc26 0.46507
CMcsdc26 cs27 dc27 7.7304e-14
Kcsdc27 Lcs27 Ldc27 0.46507
CMcsdc27 cs28 dc28 7.7304e-14
Kcsdc28 Lcs28 Ldc28 0.46507
CMcsdc28 cs29 dc29 7.7304e-14
Kcsdc29 Lcs29 Ldc29 0.46507
CMcsdc29 cs30 dc30 7.7304e-14
Kcsdc30 Lcs30 Ldc30 0.46507
CMcsdc30 cs31 dc31 7.7304e-14
Kcsdc31 Lcs31 Ldc31 0.46507
CMcsdc31 cs32 dc32 7.7304e-14
Kcsdc32 Lcs32 Ldc32 0.46507
CMcsdc32 cs33 dc33 7.7304e-14
Kcsdc33 Lcs33 Ldc33 0.46507
CMcsdc33 cs34 dc34 7.7304e-14
Kcsdc34 Lcs34 Ldc34 0.46507
CMcsdc34 cs35 dc35 7.7304e-14
Kcsdc35 Lcs35 Ldc35 0.46507
CMcsdc35 cs36 dc36 7.7304e-14
Kcsdc36 Lcs36 Ldc36 0.46507
CMcsdc36 cs37 dc37 7.7304e-14
Kcsdc37 Lcs37 Ldc37 0.46507
CMcsdc37 cs38 dc38 7.7304e-14
Kcsdc38 Lcs38 Ldc38 0.46507
CMcsdc38 cs39 dc39 7.7304e-14
Kcsdc39 Lcs39 Ldc39 0.46507
CMcsdc39 cs40 dc40 7.7304e-14
Vsclk sclk_s 0 PULSE(0 3.3 2n 7.5e-10 7.5e-10 1.175e-08 2.5e-08)
RSsclk sclk_s sclk0 53
CRXsclk sclk40 0 6p
RSmosi mosi0 0 53
CRXmosi mosi40 0 6p
RScs cs0 0 53
CRXcs cs40 0 6p
RSdc dc0 0 53
CRXdc dc40 0 6p
.tran 5p 120n 0 5p
.end
