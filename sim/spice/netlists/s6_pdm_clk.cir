* S6 pdm_clk
VSRC src 0 PULSE(0 3.3 2n 1.25e-09 1.25e-09 1.615e-07 3.255e-07)
ROUT src pad 30
CPAD pad 0 3p
RS pad a 33
Lmb0 a mb0m 1.5e-09
Rmb0 mb0m mb0 1e-06
Cmb0 mb0 0 6e-13
Lmb1 mb0 mb1m 1.5e-09
Rmb1 mb1m mb1 1e-06
Cmb1 mb1 0 6e-13
Lmb2 mb1 mb2m 1.5e-09
Rmb2 mb2m mb2 1e-06
Cmb2 mb2 0 6e-13
Lmb3 mb2 mb3m 1.5e-09
Rmb3 mb3m mb3 1e-06
Cmb3 mb3 0 6e-13
Lmb4 mb3 mb4m 1.5e-09
Rmb4 mb4m mb4 1e-06
Cmb4 mb4 0 6e-13
Lmb5 mb4 mb5m 1.5e-09
Rmb5 mb5m mb5 1e-06
Cmb5 mb5 0 6e-13
Lmb6 mb5 mb6m 1.5e-09
Rmb6 mb6m mb6 1e-06
Cmb6 mb6 0 6e-13
Lmb7 mb6 mb7m 1.5e-09
Rmb7 mb7m b 1e-06
Cmb7 b 0 6e-13
LC1 b c 2.0n
CC1 c 0 0.3p
Lffc0 c ffc0m 2.2443e-09
Rffc0 ffc0m ffc0 0.01
Cffc0 ffc0 0 1.9341e-13
Lffc1 ffc0 ffc1m 2.2443e-09
Rffc1 ffc1m ffc1 0.01
Cffc1 ffc1 0 1.9341e-13
Lffc2 ffc1 ffc2m 2.2443e-09
Rffc2 ffc2m ffc2 0.01
Cffc2 ffc2 0 1.9341e-13
Lffc3 ffc2 ffc3m 2.2443e-09
Rffc3 ffc3m ffc3 0.01
Cffc3 ffc3 0 1.9341e-13
Lffc4 ffc3 ffc4m 2.2443e-09
Rffc4 ffc4m ffc4 0.01
Cffc4 ffc4 0 1.9341e-13
Lffc5 ffc4 ffc5m 2.2443e-09
Rffc5 ffc5m ffc5 0.01
Cffc5 ffc5 0 1.9341e-13
Lffc6 ffc5 ffc6m 2.2443e-09
Rffc6 ffc6m ffc6 0.01
Cffc6 ffc6 0 1.9341e-13
Lffc7 ffc6 ffc7m 2.2443e-09
Rffc7 ffc7m ffc7 0.01
Cffc7 ffc7 0 1.9341e-13
Lffc8 ffc7 ffc8m 2.2443e-09
Rffc8 ffc8m ffc8 0.01
Cffc8 ffc8 0 1.9341e-13
Lffc9 ffc8 ffc9m 2.2443e-09
Rffc9 ffc9m ffc9 0.01
Cffc9 ffc9 0 1.9341e-13
Lffc10 ffc9 ffc10m 2.2443e-09
Rffc10 ffc10m ffc10 0.01
Cffc10 ffc10 0 1.9341e-13
Lffc11 ffc10 ffc11m 2.2443e-09
Rffc11 ffc11m ffc11 0.01
Cffc11 ffc11 0 1.9341e-13
Lffc12 ffc11 ffc12m 2.2443e-09
Rffc12 ffc12m ffc12 0.01
Cffc12 ffc12 0 1.9341e-13
Lffc13 ffc12 ffc13m 2.2443e-09
Rffc13 ffc13m ffc13 0.01
Cffc13 ffc13 0 1.9341e-13
Lffc14 ffc13 ffc14m 2.2443e-09
Rffc14 ffc14m ffc14 0.01
Cffc14 ffc14 0 1.9341e-13
Lffc15 ffc14 ffc15m 2.2443e-09
Rffc15 ffc15m ffc15 0.01
Cffc15 ffc15 0 1.9341e-13
Lffc16 ffc15 ffc16m 2.2443e-09
Rffc16 ffc16m ffc16 0.01
Cffc16 ffc16 0 1.9341e-13
Lffc17 ffc16 ffc17m 2.2443e-09
Rffc17 ffc17m ffc17 0.01
Cffc17 ffc17 0 1.9341e-13
Lffc18 ffc17 ffc18m 2.2443e-09
Rffc18 ffc18m ffc18 0.01
Cffc18 ffc18 0 1.9341e-13
Lffc19 ffc18 ffc19m 2.2443e-09
Rffc19 ffc19m ffc19 0.01
Cffc19 ffc19 0 1.9341e-13
Lffc20 ffc19 ffc20m 2.2443e-09
Rffc20 ffc20m ffc20 0.01
Cffc20 ffc20 0 1.9341e-13
Lffc21 ffc20 ffc21m 2.2443e-09
Rffc21 ffc21m ffc21 0.01
Cffc21 ffc21 0 1.9341e-13
Lffc22 ffc21 ffc22m 2.2443e-09
Rffc22 ffc22m ffc22 0.01
Cffc22 ffc22 0 1.9341e-13
Lffc23 ffc22 ffc23m 2.2443e-09
Rffc23 ffc23m ffc23 0.01
Cffc23 ffc23 0 1.9341e-13
Lffc24 ffc23 ffc24m 2.2443e-09
Rffc24 ffc24m ffc24 0.01
Cffc24 ffc24 0 1.9341e-13
Lffc25 ffc24 ffc25m 2.2443e-09
Rffc25 ffc25m ffc25 0.01
Cffc25 ffc25 0 1.9341e-13
Lffc26 ffc25 ffc26m 2.2443e-09
Rffc26 ffc26m ffc26 0.01
Cffc26 ffc26 0 1.9341e-13
Lffc27 ffc26 ffc27m 2.2443e-09
Rffc27 ffc27m ffc27 0.01
Cffc27 ffc27 0 1.9341e-13
Lffc28 ffc27 ffc28m 2.2443e-09
Rffc28 ffc28m ffc28 0.01
Cffc28 ffc28 0 1.9341e-13
Lffc29 ffc28 ffc29m 2.2443e-09
Rffc29 ffc29m ffc29 0.01
Cffc29 ffc29 0 1.9341e-13
Lffc30 ffc29 ffc30m 2.2443e-09
Rffc30 ffc30m ffc30 0.01
Cffc30 ffc30 0 1.9341e-13
Lffc31 ffc30 ffc31m 2.2443e-09
Rffc31 ffc31m ffc31 0.01
Cffc31 ffc31 0 1.9341e-13
Lffc32 ffc31 ffc32m 2.2443e-09
Rffc32 ffc32m ffc32 0.01
Cffc32 ffc32 0 1.9341e-13
Lffc33 ffc32 ffc33m 2.2443e-09
Rffc33 ffc33m ffc33 0.01
Cffc33 ffc33 0 1.9341e-13
Lffc34 ffc33 ffc34m 2.2443e-09
Rffc34 ffc34m ffc34 0.01
Cffc34 ffc34 0 1.9341e-13
Lffc35 ffc34 ffc35m 2.2443e-09
Rffc35 ffc35m ffc35 0.01
Cffc35 ffc35 0 1.9341e-13
Lffc36 ffc35 ffc36m 2.2443e-09
Rffc36 ffc36m ffc36 0.01
Cffc36 ffc36 0 1.9341e-13
Lffc37 ffc36 ffc37m 2.2443e-09
Rffc37 ffc37m ffc37 0.01
Cffc37 ffc37 0 1.9341e-13
Lffc38 ffc37 ffc38m 2.2443e-09
Rffc38 ffc38m ffc38 0.01
Cffc38 ffc38 0 1.9341e-13
Lffc39 ffc38 ffc39m 2.2443e-09
Rffc39 ffc39m d 0.01
Cffc39 d 0 1.9341e-13
LC2 d e 2.0n
CC2 e 0 0.3p
Lui0 e ui0m 1.375e-09
Rui0 ui0m ui0 1e-06
Cui0 ui0 0 4.5455e-13
Lui1 ui0 ui1m 1.375e-09
Rui1 ui1m ui1 1e-06
Cui1 ui1 0 4.5455e-13
Lui2 ui1 ui2m 1.375e-09
Rui2 ui2m ui2 1e-06
Cui2 ui2 0 4.5455e-13
Lui3 ui2 ui3m 1.375e-09
Rui3 ui3m ui3 1e-06
Cui3 ui3 0 4.5455e-13
Lui4 ui3 ui4m 1.375e-09
Rui4 ui4m ui4 1e-06
Cui4 ui4 0 4.5455e-13
Lui5 ui4 ui5m 1.375e-09
Rui5 ui5m f 1e-06
Cui5 f 0 4.5455e-13
Ldm0 f dm0m 1.75e-09
Rdm0 dm0m dm0 1e-06
Cdm0 dm0 0 3.5714e-13
Ldm1 dm0 dm1m 1.75e-09
Rdm1 dm1m dm1 1e-06
Cdm1 dm1 0 3.5714e-13
Ldm2 dm1 dm2m 1.75e-09
Rdm2 dm2m dm2 1e-06
Cdm2 dm2 0 3.5714e-13
Ldm3 dm2 dm3m 1.75e-09
Rdm3 dm3m dm3 1e-06
Cdm3 dm3 0 3.5714e-13
Ldm4 dm3 dm4m 1.75e-09
Rdm4 dm4m dm4 1e-06
Cdm4 dm4 0 3.5714e-13
Ldm5 dm4 dm5m 1.75e-09
Rdm5 dm5m rx 1e-06
Cdm5 rx 0 3.5714e-13
CRX rx 0 3e-12
.tran 20p 700n 0 20p
.end
